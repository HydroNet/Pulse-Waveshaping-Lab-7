** Profile: "SCHEMATIC1-lab7"  [ C:\Users\Harry\Desktop\Spring 2022 CSUN\ECE 443L\Lab 7\lab7-pspicefiles\schematic1\lab7.sim ]

** Creating circuit file "lab7.cir"
** WARNING: THIS AUTOMATICALLY GENERATED FILE MAY BE OVERWRITTEN BY SUBSEQUENT SIMULATIONS

*Libraries:
* Profile Libraries :
* Local Libraries :
.LIB "../../../lab7-pspicefiles/lab7.lib"
* From [PSPICE NETLIST] section of C:\Users\Harry\AppData\Roaming\SPB_Data\cdssetup\OrCAD_PSpice\17.2.0\PSpice.ini file:
.lib "nomd.lib"

*Analysis directives:
.TRAN  0 7.5u 0 1ns
.OPTIONS ADVCONV
.PROBE64 V(alias(*)) I(alias(*)) W(alias(*)) D(alias(*)) NOISE(alias(*))
.INC "..\SCHEMATIC1.net"

.END
